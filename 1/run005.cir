opamp_XR.U1
.SUBCKT IDEAL_OPAMP INP INN OUT
E1 N1 0 INP INN 1.000000000e+05
R1 N1 N2 1.000000000e+03
C1 N2 0 1.591549431e-06
E2 OUT 0 N2 0 1.000000000e+00
.ENDS IDEAL_OPAMP
RXR.RL inR 0 47k
CXR.CIN inR XR.amp 100n
RXR.RB XR.amp 0 1meg
RXR.RG XR.fb XR.ng 100
CXR.CG XR.ng 0 470u
RXR.R7 outR XR.f1 88.7k
CXR.C5 outR XR.f1 36n
RXR.R8 XR.f1 XR.fb 7.5k
CXR.C6 XR.f1 XR.fb 10n
V_vp vp 0 DC 1.500000000e+01
V_vn vn 0 DC -1.500000000e+01
R_LEAK_inR inR 0 1.000000000e+09
R_LEAK_outR outR 0 1.000000000e+09
VAC_IN inR 0 DC 0 AC 1
XXR.U1 XR.amp XR.fb outR IDEAL_OPAMP
.ac dec 20 2.000000000e+01 2.000000000e+04
.control
run
set filetype=ascii
write 1/run005.raw
.endc
.END
