opamp_U1B
.SUBCKT IDEAL_OPAMP INP INN OUT
E1 N1 0 INP INN 1.000000000e+05
R1 N1 N2 1.000000000e+03
C1 N2 0 1.591549431e-05
E2 OUT 0 N2 0 1.000000000e+00
.ENDS IDEAL_OPAMP
R9 vin 0 100k
R1 vin na 10k
R2 na nb 10k
C1 na vo1 820p
C2 nb 0 680p
R3 vo1 nc 10k
R4 nc nd 10k
C3 nc vout 2.2n
C4 nd 0 330p
EU1A_AOL U1A_N1 0 nb vo1 1.000000000e+05
RU1A_POLE U1A_N1 U1A_N2 1.000000000e+03
CU1A_POLE U1A_N2 0 1.591549431e-05
EU1A_BUF vo1 0 U1A_N2 0 1.000000000e+00
V_vcc vcc 0 DC 5.000000000e+00
V_vee vee 0 DC -5.000000000e+00
R_LEAK_vin vin 0 1.000000000e+09
R_LEAK_vout vout 0 1.000000000e+09
VAC_IN vin 0 DC 0 AC 1
XU1B nd vout vout IDEAL_OPAMP
.ac dec 20 1.000000000e+00 1.000000000e+08
.control
run
set filetype=ascii
write 1/run007.raw
.endc
.END
