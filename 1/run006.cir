aa_filter
V1 vcc 0 DC 5
V2 vee 0 DC -5
C10 vcc 0 10u
C11 vcc 0 100n
C12 vee 0 10u
C13 vee 0 100n
R9 vin 0 100k
R1 vin na 10k
R2 na nb 10k
C1 na vo1 820p
C2 nb 0 680p
R3 vo1 nc 10k
R4 nc nd 10k
C3 nc vout 2.2n
C4 nd 0 330p
EU1A_AOL U1A_N1 0 nb vo1 1.000000000e+05
RU1A_POLE U1A_N1 U1A_N2 1.000000000e+03
CU1A_POLE U1A_N2 0 1.591549431e-05
EU1A_BUF vo1 0 U1A_N2 0 1.000000000e+00
EU1B_AOL U1B_N1 0 nd vout 1.000000000e+05
RU1B_POLE U1B_N1 U1B_N2 1.000000000e+03
CU1B_POLE U1B_N2 0 1.591549431e-05
EU1B_BUF vout 0 U1B_N2 0 1.000000000e+00
.op
.control
run
set filetype=ascii
write 1/run006.raw
.endc
.END
