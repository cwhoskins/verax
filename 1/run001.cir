pdn_vp
V1 V1_ROUT_N 0 DC 15
C1 vp C1_ESR_N 220u
CXL.CD1 vp XL.CD1_ESR_N 6.500000000e-08
CXR.CD1 vp XR.CD1_ESR_N 6.500000000e-08
V_vn V_vn_ROUT_N 0 DC -1.500000000e+01
R_LEAK_vp vp 0 1.000000000e+09
RC1_ESR C1_ESR_N C1_ESL_N 1.500000000e-01
LC1_ESL C1_ESL_N 0 6.000000000e-09
RXL.CD1_ESR XL.CD1_ESR_N XL.CD1_ESL_N 3.000000000e-02
LXL.CD1_ESL XL.CD1_ESL_N 0 6.000000000e-10
RXR.CD1_ESR XR.CD1_ESR_N XR.CD1_ESL_N 3.000000000e-02
LXR.CD1_ESL XR.CD1_ESL_N 0 6.000000000e-10
RV1_ROUT V1_ROUT_N V1_LOUT_N 1.000000000e-02
LV1_LOUT V1_LOUT_N vp 1.000000000e-06
RV_vn_ROUT V_vn_ROUT_N V_vn_LOUT_N 1.000000000e-02
LV_vn_LOUT V_vn_LOUT_N vn 1.000000000e-06
IPROBE_vp 0 vp DC 0 AC 1.000000000e+00
.ac dec 20 1.000000000e+03 1.000000000e+09
.control
run
set filetype=ascii
write 1/run001.raw
.endc
.END
