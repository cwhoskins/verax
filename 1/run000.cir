riaa_preamp
V1 vp 0 DC 15
V2 vn 0 DC -15
C1 vp 0 220u
C2 vn 0 220u
RXL.RL inL 0 47k
CXL.CIN inL XL.amp 100n
RXL.RB XL.amp 0 1meg
RXL.RG XL.fb XL.ng 100
CXL.CG XL.ng 0 470u
RXL.R7 outL XL.f1 88.7k
CXL.C5 outL XL.f1 36n
RXL.R8 XL.f1 XL.fb 7.5k
CXL.C6 XL.f1 XL.fb 10n
CXL.CD1 vp 0 100n
CXL.CD2 vn 0 100n
RXR.RL inR 0 47k
CXR.CIN inR XR.amp 100n
RXR.RB XR.amp 0 1meg
RXR.RG XR.fb XR.ng 100
CXR.CG XR.ng 0 470u
RXR.R7 outR XR.f1 88.7k
CXR.C5 outR XR.f1 36n
RXR.R8 XR.f1 XR.fb 7.5k
CXR.C6 XR.f1 XR.fb 10n
CXR.CD1 vp 0 100n
CXR.CD2 vn 0 100n
EXL.U1_AOL XL.U1_N1 0 XL.amp XL.fb 1.000000000e+05
RXL.U1_POLE XL.U1_N1 XL.U1_N2 1.000000000e+03
CXL.U1_POLE XL.U1_N2 0 1.591549431e-06
EXL.U1_BUF outL 0 XL.U1_N2 0 1.000000000e+00
EXR.U1_AOL XR.U1_N1 0 XR.amp XR.fb 1.000000000e+05
RXR.U1_POLE XR.U1_N1 XR.U1_N2 1.000000000e+03
CXR.U1_POLE XR.U1_N2 0 1.591549431e-06
EXR.U1_BUF outR 0 XR.U1_N2 0 1.000000000e+00
.op
.control
run
set filetype=ascii
write 1/run000.raw
.endc
.END
