opamp_XL.U1
.SUBCKT IDEAL_OPAMP INP INN OUT
E1 N1 0 INP INN 1.000000000e+05
R1 N1 N2 1.000000000e+03
C1 N2 0 1.591549431e-06
E2 OUT 0 N2 0 1.000000000e+00
.ENDS IDEAL_OPAMP
RXL.RL inL 0 47k
CXL.CIN inL XL.amp 100n
RXL.RB XL.amp 0 1meg
RXL.RG XL.fb XL.ng 100
CXL.CG XL.ng 0 470u
RXL.R7 outL XL.f1 88.7k
CXL.C5 outL XL.f1 36n
RXL.R8 XL.f1 XL.fb 7.5k
CXL.C6 XL.f1 XL.fb 10n
V_vp vp 0 DC 1.500000000e+01
V_vn vn 0 DC -1.500000000e+01
R_LEAK_inL inL 0 1.000000000e+09
R_LEAK_outL outL 0 1.000000000e+09
VAC_IN inL 0 DC 0 AC 1
XXL.U1 XL.amp XL.fb outL IDEAL_OPAMP
.ac dec 20 1.000000000e+00 1.000000000e+08
.control
run
set filetype=ascii
write 1/run002.raw
.endc
.END
